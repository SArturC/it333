Conversor Buck source ex4.cir
*
* Implementação do conversor buck
* Nível 2: componentes ideais, MOSFET modelo IRF1503
* Erickson, seção 2.2
*
* *****************************************

* DESCRIÇÃO DO CIRCUITO
* variáveis do circuito
.param vg   = 20       ; fonte de entrada
.param fsw  = 2.5e4    ; frequência do sinal da fonte
.param per  = {1/fsw}  ; período do sinal da fonte
.param dut  = 0.5      ; ciclo de trabalho

* definição dos componentes
* pwm source
vpwm  n01  ns1  PULSE(-15 15 0 1e-7 1e-7 {dut*per} {per})
rpwm  n01  pwm  1.0e2

* entrada
vg1 nd1  GND  DC  {vg}

* transistor
m1  nd1  pwm  ns1  GND  IRF1405
d1  GND  ns1  Dideal

* circuito de saída
l1  ns1   vout  1.00e-4  IC=0.0e0
c1  vout  GND   1.00e-4  IC=0.0e0
rl  vout  GND   2.0e1

* definição dos modelos
.model IRF1405 VDMOS ( Rg=3        Vto=3.9      Rd=0.6m
+                      Rs=1.1m     Rb=2.97m     Kp=59
+                      Cgdmax=8.1n Cgdmin=0.34n Cgs=6.5n
+                      Cjo=3.2n    Is=33p       Vds=55
+                      Ron=4.6m    Qg=170n )
.model Dideal D( RS=1e-12 IS=1.0e-3 N=1
+                TT=0 CJO=0 )

* COMANDOS DA SIMULAÇÃO
.options savecurrents TEMP = 27

* PARÂMETROS DA SIMULAÇÃO
.tran {per/100} {150*per}

.control ;
run
plot vout
plot @l1[i]
plot -v(ns1)

.endc
.end
