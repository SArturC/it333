Conversor Flayback source ex4.cir
*
* Implementação do conversor Flayback
* Nível 1: transistor como chave e componentes ideias
* Erickson, seção 6.3
*
* *****************************************

* DESCRIÇÃO DO CIRCUITO
* variáveis do circuito
.param vg    = 3.6e1      ; fonte de entrada
.param apwm  = 1.0e1      ; fonte de entrada
.param fsw   = 1.0e5      ; frequência do sinal da fonte
.param per   = {1/fsw}    ; período do sinal da fonte
.param dut   = 0.4        ; ciclo de trabalho
.param km2   = 0.999; 1   ; coeficiente de acomplamento
.param lm    = 1.0e-4     ; indutância de magnetização primário
.param n     = 0.5        ; relação de transformação
.param l2    = {lm*(n*n)} ; indutância do secundário
.param c     = 5.0e-5     ; capacitância de saída
.param rpwm  = 1.0e1      ; resistência de gate
.param rl    = 2.0e1      ; resistência de carga
.param rc    = 2.6e3      ; resistência do Clamper RCD
.param cc    = 1.92e-8    ; capacitância do Clamper RCD
.param rs    = 8.01e1     ; resistência do Snubber
.param cs    = 9.945e-10  ; capacitância do Snubber

* definição dos componentes
* pwm source
Vpwm  n01  GND  PULSE(0 {apwm} 0 1e-9 1e-9 {dut*per} {per})
Rpwm  n01  pwm  {rpwm}

* primário
Vg  nl2  GND  DC    {vg}
Lm  nl1  nl2  {lm}  IC=0
M1  nl1  pwm  GND   GND   IRFH5007
* clamper RCD
Rc  nl2  n03  {rc}
Cc  nl2  n03  {cc}
Dc  nl1  n03  Dideal
* snubber
Cs  nl1  n04  {cs}
Rs  n04  GND  {rs}

* secundário
L2  n02   GND   {l2}
D1  n02   nout  Dideal
C1  nout  GND   {c}
Rl  nout  GND   {rl}

* acoplamento das indutâncias
K12 Lm L2 {km2}

* definição dos modelos
.model IRFH5007 VDMOS( Rg=1.2      Vto=3.65     Rd=3.7m
+                      Rs=0.10m    Rb=1.20m     Kp=121
+                      Cgdmax=2.5n Cgdmin=0.24n Cgs=2.7n
+                      Cjo=1.5n    Is=9p        tt=31n
+                      Vds=75      Ron=5.1m     Qg=65n )
.model Dideal D( RS=1e-6 IS=1.0e-6 N=1
+                TT=0 CJO=0 )

* COMANDOS DA SIMULAÇÃO
.options savecurrents TEMP = 27

* PARÂMETROS DA SIMULAÇÃO
.IC v(nout) = 0.0e0
.tran {per/100} {500*per} uic

.control ;
run
plot @m1[id]
plot nl1
plot nout

* SALVAMENTO DOS DADOS
set wr_singlescale
set wr_vecnames
set filetype=ascii
wrdata ex4_4.csv @m1[id] v(nl1) (nout)
.endc
.end
